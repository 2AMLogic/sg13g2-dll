* sg13g2-dll :: delay_cell -- generated by design/netlist.sh from design/delay_cell.sch
* do not edit by hand; regenerate with design/netlist.sh
** sch_path: design/delay_cell.sch
.subckt delay_cell IN VBP VBN OUT VDD VSS
*.ipin IN
*.ipin VBP
*.ipin VBN
*.opin OUT
*.iopin VDD
*.iopin VSS
XMPH1 nh1 VBP VDD VDD sg13_lv_pmos w=1.5u l=0.13u ng=1 m=1
XMP1 mid IN nh1 VDD sg13_lv_pmos w=1u l=0.13u ng=1 m=1
XMN1 mid IN nt1 VSS sg13_lv_nmos w=0.5u l=0.13u ng=1 m=1
XMNT1 nt1 VBN VSS VSS sg13_lv_nmos w=0.75u l=0.13u ng=1 m=1
XMPH2 nh2 VBP VDD VDD sg13_lv_pmos w=1.5u l=0.13u ng=1 m=1
XMP2 OUT mid nh2 VDD sg13_lv_pmos w=1u l=0.13u ng=1 m=1
XMN2 OUT mid nt2 VSS sg13_lv_nmos w=0.5u l=0.13u ng=1 m=1
XMNT2 nt2 VBN VSS VSS sg13_lv_nmos w=0.75u l=0.13u ng=1 m=1
.ends
