* sg13g2-dll :: tap_buffer -- generated by design/netlist.sh from design/tap_buffer.sch
* do not edit by hand; regenerate with design/netlist.sh
** sch_path: design/tap_buffer.sch
.subckt tap_buffer IN OUT VDD VSS
*.ipin IN
*.opin OUT
*.iopin VDD
*.iopin VSS
XMP1 b IN VDD VDD sg13_lv_pmos w=0.5u l=0.13u ng=1 m=1
XMN1 b IN VSS VSS sg13_lv_nmos w=0.25u l=0.13u ng=1 m=1
XMP2 OUT b VDD VDD sg13_lv_pmos w=3u l=0.13u ng=1 m=1
XMN2 OUT b VSS VSS sg13_lv_nmos w=1.5u l=0.13u ng=1 m=1
.ends
