* sg13g2-dll :: loop_filter -- generated by design/netlist.sh from design/loop_filter.sch
* do not edit by hand; regenerate with design/netlist.sh
** sch_path: design/loop_filter.sch
.subckt loop_filter VCTRL VSS
*.iopin VCTRL
*.iopin VSS
XC1 VCTRL VSS cap_cmim w=26u l=26u m=1
.ends
