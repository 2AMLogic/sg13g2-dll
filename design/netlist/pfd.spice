* sg13g2-dll :: pfd -- generated by design/netlist.sh from design/pfd.sch
* do not edit by hand; regenerate with design/netlist.sh
** sch_path: design/pfd.sch
.subckt pfd REF FB UP DN VDD VSS
*.ipin REF
*.ipin FB
*.opin UP
*.opin DN
*.iopin VDD
*.iopin VSS
XED_UP REF set_up VDD VSS edgedet
XED_DN FB set_dn VDD VSS edgedet
XLU set_up reset_n UP upb_n VDD VSS srlatch_fast
XLD set_dn reset_n DN dnb_n VDD VSS srlatch_fast
XNR UP DN reset_n VDD VSS nand4x_lv
.ends

* expanding   symbol:  edgedet.sym # of pins=4
** sym_path: design/edgedet.sym
** sch_path: design/edgedet.sch
.subckt edgedet X OUT VDD VSS
*.ipin X
*.opin OUT
*.iopin VDD
*.iopin VSS
XD1 X d1 VDD VSS inv_lv
XD2 d1 d2 VDD VSS inv_lv
XD3 d2 d3 VDD VSS inv_lv
XD4 d3 d4 VDD VSS inv_lv
XD5 d4 d5 VDD VSS inv_lv
XN1 X d5 ntmp VDD VSS nand2_lv
XOUT ntmp OUT VDD VSS inv_lv
.ends

* expanding   symbol:  srlatch_fast.sym # of pins=6
** sym_path: design/srlatch_fast.sym
** sch_path: design/srlatch_fast.sch
.subckt srlatch_fast S RN Q QB VDD VSS
*.ipin S
*.ipin RN
*.opin Q
*.opin QB
*.iopin VDD
*.iopin VSS
XIS S SB VDD VSS inv4x_lv
XNQ SB QB Q VDD VSS nand2x_lv
XNQB RN Q QB VDD VSS nand4x_lv
.ends

* expanding   symbol:  nand4x_lv.sym # of pins=5
** sym_path: design/nand4x_lv.sym
** sch_path: design/nand4x_lv.sch
.subckt nand4x_lv A1 A2 Y VDD VSS
*.ipin A1
*.ipin A2
*.opin Y
*.iopin VDD
*.iopin VSS
XMP1 Y A1 VDD VDD sg13_lv_pmos w=4u l=0.13u ng=1 m=1
XMP2 Y A2 VDD VDD sg13_lv_pmos w=4u l=0.13u ng=1 m=1
XMN1 Y A1 mid VSS sg13_lv_nmos w=4u l=0.13u ng=1 m=1
XMN2 mid A2 VSS VSS sg13_lv_nmos w=4u l=0.13u ng=1 m=1
.ends

* expanding   symbol:  inv_lv.sym # of pins=4
** sym_path: design/inv_lv.sym
** sch_path: design/inv_lv.sch
.subckt inv_lv A Y VDD VSS
*.ipin A
*.opin Y
*.iopin VDD
*.iopin VSS
XMP Y A VDD VDD sg13_lv_pmos w=1u l=0.13u ng=1 m=1
XMN Y A VSS VSS sg13_lv_nmos w=0.5u l=0.13u ng=1 m=1
.ends

* expanding   symbol:  nand2_lv.sym # of pins=5
** sym_path: design/nand2_lv.sym
** sch_path: design/nand2_lv.sch
.subckt nand2_lv A1 A2 Y VDD VSS
*.ipin A1
*.ipin A2
*.opin Y
*.iopin VDD
*.iopin VSS
XMP1 Y A1 VDD VDD sg13_lv_pmos w=1u l=0.13u ng=1 m=1
XMP2 Y A2 VDD VDD sg13_lv_pmos w=1u l=0.13u ng=1 m=1
XMN1 Y A1 mid VSS sg13_lv_nmos w=1u l=0.13u ng=1 m=1
XMN2 mid A2 VSS VSS sg13_lv_nmos w=1u l=0.13u ng=1 m=1
.ends

* expanding   symbol:  inv4x_lv.sym # of pins=4
** sym_path: design/inv4x_lv.sym
** sch_path: design/inv4x_lv.sch
.subckt inv4x_lv A Y VDD VSS
*.ipin A
*.opin Y
*.iopin VDD
*.iopin VSS
XMP Y A VDD VDD sg13_lv_pmos w=4u l=0.13u ng=1 m=1
XMN Y A VSS VSS sg13_lv_nmos w=2u l=0.13u ng=1 m=1
.ends

* expanding   symbol:  nand2x_lv.sym # of pins=5
** sym_path: design/nand2x_lv.sym
** sch_path: design/nand2x_lv.sch
.subckt nand2x_lv A1 A2 Y VDD VSS
*.ipin A1
*.ipin A2
*.opin Y
*.iopin VDD
*.iopin VSS
XMP1 Y A1 VDD VDD sg13_lv_pmos w=2u l=0.13u ng=1 m=1
XMP2 Y A2 VDD VDD sg13_lv_pmos w=2u l=0.13u ng=1 m=1
XMN1 Y A1 mid VSS sg13_lv_nmos w=2u l=0.13u ng=1 m=1
XMN2 mid A2 VSS VSS sg13_lv_nmos w=2u l=0.13u ng=1 m=1
.ends
