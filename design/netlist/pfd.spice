* sg13g2-dll :: pfd -- generated by design/netlist.sh from design/pfd.sch
* do not edit by hand; regenerate with design/netlist.sh
** sch_path: design/pfd.sch
.subckt pfd REF FB UP DN VDD VSS
*.ipin REF
*.ipin FB
*.opin UP
*.opin DN
*.iopin VDD
*.iopin VSS
XED_UP REF set_up VDD VSS edgedet
XED_DN FB set_dn VDD VSS edgedet
XLU set_up reset UP up_qb up_qn VDD VSS srlatch_buf
XLD set_dn reset DN dn_qb dn_qn VDD VSS srlatch_buf
XNR up_qn dn_qn reset_n0 VDD VSS nand2x_lv
XR1 reset_n0 reset VDD VSS inv4x_lv
.ends

* expanding   symbol:  edgedet.sym # of pins=4
** sym_path: design/edgedet.sym
** sch_path: design/edgedet.sch
.subckt edgedet X OUT VDD VSS
*.ipin X
*.opin OUT
*.iopin VDD
*.iopin VSS
XMPD1 d1 X VDD VDD sg13_lv_pmos w=1u l=0.16u ng=1 m=1
XMND1 d1 X VSS VSS sg13_lv_nmos w=0.5u l=0.16u ng=1 m=1
XMPD2 d2 d1 VDD VDD sg13_lv_pmos w=1u l=0.16u ng=1 m=1
XMND2 d2 d1 VSS VSS sg13_lv_nmos w=0.5u l=0.16u ng=1 m=1
XMPD3 d3 d2 VDD VDD sg13_lv_pmos w=1u l=0.16u ng=1 m=1
XMND3 d3 d2 VSS VSS sg13_lv_nmos w=0.5u l=0.16u ng=1 m=1
XN1 X d3 ntmp VDD VSS nand2_lv
XOUT ntmp OUT VDD VSS inv_lv
.ends

* expanding   symbol:  srlatch_buf.sym # of pins=7
** sym_path: design/srlatch_buf.sym
** sch_path: design/srlatch_buf.sch
.subckt srlatch_buf S R Q QB QN VDD VSS
*.ipin S
*.ipin R
*.opin Q
*.opin QB
*.opin QN
*.iopin VDD
*.iopin VSS
XIS S SB VDD VSS inv2x_lv
XIR R RB VDD VSS inv4x_lv
XMPQ1 QN SB VDD VDD sg13_lv_pmos w=4u l=0.13u ng=1 m=1
XMPQ2 QN QB VDD VDD sg13_lv_pmos w=4u l=0.13u ng=1 m=1
XMNQ1 QN SB midq VSS sg13_lv_nmos w=4u l=0.13u ng=1 m=1
XMNQ2 midq QB VSS VSS sg13_lv_nmos w=4u l=0.13u ng=1 m=1
XMPB1 QB RB VDD VDD sg13_lv_pmos w=4u l=0.13u ng=1 m=1
XMPB2 QB QN VDD VDD sg13_lv_pmos w=4u l=0.13u ng=1 m=1
XMNB1 QB RB midb VSS sg13_lv_nmos w=4u l=0.13u ng=1 m=1
XMNB2 midb QN VSS VSS sg13_lv_nmos w=4u l=0.13u ng=1 m=1
XOQ QB Q VDD VSS inv4x_lv
.ends

* expanding   symbol:  nand2x_lv.sym # of pins=5
** sym_path: design/nand2x_lv.sym
** sch_path: design/nand2x_lv.sch
.subckt nand2x_lv A1 A2 Y VDD VSS
*.ipin A1
*.ipin A2
*.opin Y
*.iopin VDD
*.iopin VSS
XMP1 Y A1 VDD VDD sg13_lv_pmos w=2u l=0.13u ng=1 m=1
XMP2 Y A2 VDD VDD sg13_lv_pmos w=2u l=0.13u ng=1 m=1
XMN1 Y A1 mid VSS sg13_lv_nmos w=2u l=0.13u ng=1 m=1
XMN2 mid A2 VSS VSS sg13_lv_nmos w=2u l=0.13u ng=1 m=1
.ends

* expanding   symbol:  inv4x_lv.sym # of pins=4
** sym_path: design/inv4x_lv.sym
** sch_path: design/inv4x_lv.sch
.subckt inv4x_lv A Y VDD VSS
*.ipin A
*.opin Y
*.iopin VDD
*.iopin VSS
XMP Y A VDD VDD sg13_lv_pmos w=4u l=0.13u ng=1 m=1
XMN Y A VSS VSS sg13_lv_nmos w=2u l=0.13u ng=1 m=1
.ends

* expanding   symbol:  nand2_lv.sym # of pins=5
** sym_path: design/nand2_lv.sym
** sch_path: design/nand2_lv.sch
.subckt nand2_lv A1 A2 Y VDD VSS
*.ipin A1
*.ipin A2
*.opin Y
*.iopin VDD
*.iopin VSS
XMP1 Y A1 VDD VDD sg13_lv_pmos w=1u l=0.13u ng=1 m=1
XMP2 Y A2 VDD VDD sg13_lv_pmos w=1u l=0.13u ng=1 m=1
XMN1 Y A1 mid VSS sg13_lv_nmos w=1u l=0.13u ng=1 m=1
XMN2 mid A2 VSS VSS sg13_lv_nmos w=1u l=0.13u ng=1 m=1
.ends

* expanding   symbol:  inv_lv.sym # of pins=4
** sym_path: design/inv_lv.sym
** sch_path: design/inv_lv.sch
.subckt inv_lv A Y VDD VSS
*.ipin A
*.opin Y
*.iopin VDD
*.iopin VSS
XMP Y A VDD VDD sg13_lv_pmos w=1u l=0.13u ng=1 m=1
XMN Y A VSS VSS sg13_lv_nmos w=0.5u l=0.13u ng=1 m=1
.ends

* expanding   symbol:  inv2x_lv.sym # of pins=4
** sym_path: design/inv2x_lv.sym
** sch_path: design/inv2x_lv.sch
.subckt inv2x_lv A Y VDD VSS
*.ipin A
*.opin Y
*.iopin VDD
*.iopin VSS
XMP Y A VDD VDD sg13_lv_pmos w=2u l=0.13u ng=1 m=1
XMN Y A VSS VSS sg13_lv_nmos w=1u l=0.13u ng=1 m=1
.ends
