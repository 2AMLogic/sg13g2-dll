* sg13g2-dll :: cp_bias -- generated by design/netlist.sh from design/cp_bias.sch
* do not edit by hand; regenerate with design/netlist.sh
** sch_path: design/cp_bias.sch
.subckt cp_bias IBP ICP IBN ICN VDD VSS
*.opin IBP
*.opin ICP
*.opin IBN
*.opin ICN
*.iopin VDD
*.iopin VSS
XMR ICN VSS VDD VDD sg13_lv_pmos w=0.5u l=4u ng=1 m=1
XMN3 ICN ICN IBN VSS sg13_lv_nmos w=2u l=0.5u ng=1 m=1
XMN0 IBN IBN VSS VSS sg13_lv_nmos w=2u l=0.5u ng=1 m=1
XMP0 IBP IBP VDD VDD sg13_lv_pmos w=6u l=0.5u ng=1 m=1
XMP3 ICP ICP IBP VDD sg13_lv_pmos w=6u l=0.5u ng=1 m=1
XMN4 ICP IBN VSS VSS sg13_lv_nmos w=2u l=0.5u ng=1 m=1
.ends
