* sg13g2-dll :: cp -- generated by design/netlist.sh from design/cp.sch
* do not edit by hand; regenerate with design/netlist.sh
** sch_path: design/cp.sch
.subckt cp UP DN IBP ICP IBN ICN VOUT VDD VSS
*.ipin UP
*.ipin DN
*.ipin IBP
*.ipin ICP
*.ipin IBN
*.ipin ICN
*.opin VOUT
*.iopin VDD
*.iopin VSS
XIUP UP UPB VDD VSS inv_lv
XIDN DN DNB VDD VSS inv_lv
XLEGP IBP ICP UP UPB VOUT VDUMP VDD cp_leg_p
XLEGN IBN ICN DN DNB VOUT VDUMP VSS cp_leg_n
XBUF VOUT IBN VDUMP VDD VSS cp_dumpbuf
.ends

* expanding   symbol:  inv_lv.sym # of pins=4
** sym_path: design/inv_lv.sym
** sch_path: design/inv_lv.sch
.subckt inv_lv A Y VDD VSS
*.ipin A
*.opin Y
*.iopin VDD
*.iopin VSS
XMP Y A VDD VDD sg13_lv_pmos w=1u l=0.13u ng=1 m=1
XMN Y A VSS VSS sg13_lv_nmos w=0.5u l=0.13u ng=1 m=1
.ends

* expanding   symbol:  cp_leg_p.sym # of pins=7
** sym_path: design/cp_leg_p.sym
** sch_path: design/cp_leg_p.sch
.subckt cp_leg_p IBP ICP UP UPB VOUT VDUMP VDD
*.ipin IBP
*.ipin ICP
*.ipin UP
*.ipin UPB
*.opin VOUT
*.opin VDUMP
*.iopin VDD
XM1 tail IBP VDD VDD sg13_lv_pmos w=6u l=0.5u ng=1 m=1
XM2 sw ICP tail VDD sg13_lv_pmos w=6u l=0.5u ng=1 m=1
XXSWO VOUT UPB sw VDD sg13_lv_pmos w=3u l=0.13u ng=1 m=1
XXSWD VDUMP UP sw VDD sg13_lv_pmos w=3u l=0.13u ng=1 m=1
.ends

* expanding   symbol:  cp_leg_n.sym # of pins=7
** sym_path: design/cp_leg_n.sym
** sch_path: design/cp_leg_n.sch
.subckt cp_leg_n IBN ICN DN DNB VOUT VDUMP VSS
*.ipin IBN
*.ipin ICN
*.ipin DN
*.ipin DNB
*.opin VOUT
*.opin VDUMP
*.iopin VSS
XM1 tail IBN VSS VSS sg13_lv_nmos w=2u l=0.5u ng=1 m=1
XM2 sw ICN tail VSS sg13_lv_nmos w=2u l=0.5u ng=1 m=1
XXSWO VOUT DN sw VSS sg13_lv_nmos w=1u l=0.13u ng=1 m=1
XXSWD VDUMP DNB sw VSS sg13_lv_nmos w=1u l=0.13u ng=1 m=1
.ends

* expanding   symbol:  cp_dumpbuf.sym # of pins=5
** sym_path: design/cp_dumpbuf.sym
** sch_path: design/cp_dumpbuf.sch
.subckt cp_dumpbuf VOUT IBIAS VDUMP VDD VSS
*.ipin VOUT
*.ipin IBIAS
*.opin VDUMP
*.iopin VDD
*.iopin VSS
XM1 VDD VOUT VDUMP VSS sg13_lv_nmos w=2u l=0.25u ng=1 m=1
XM2 VDUMP IBIAS VSS VSS sg13_lv_nmos w=1u l=0.5u ng=1 m=1
.ends
