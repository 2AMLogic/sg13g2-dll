* klt sim -- generated corner deck, do not edit
.lib /home/ubuntu/share/pdk/ihp-sg13g2/libs.tech/ngspice/models/cornerMOSlv.lib mos_tt
.lib /home/ubuntu/share/pdk/ihp-sg13g2/libs.tech/ngspice/models/cornerRES.lib res_typ
.lib /home/ubuntu/share/pdk/ihp-sg13g2/libs.tech/ngspice/models/cornerCAP.lib cap_typ
.include /home/ubuntu/GitHub/sg13g2-dll/.loom/worktrees/issue-145/sim/lock-detector-smoke/results/20261115T184954Z/requests/../decks/ld_1GHz.spice
.temp 27
.meas tran lock_max_before_220n max v(lock) from=20n to=220n
.meas tran t_rise1 when v(lock)=0.6 rise=1 td=220n
.meas tran t_fall1 when v(lock)=0.6 fall=1 td=480n
.meas tran t_rise2 when v(lock)=0.6 rise=1 td=530n
.meas tran t_edge_lock trig v(lock) val=0.12 rise=2 targ v(lock) val=1.08 rise=2
.control
pre_osdi /home/ubuntu/share/pdk/ihp-sg13g2/libs.tech/ngspice/osdi/psp103.osdi
pre_osdi /home/ubuntu/share/pdk/ihp-sg13g2/libs.tech/ngspice/osdi/psp103_nqs.osdi
pre_osdi /home/ubuntu/share/pdk/ihp-sg13g2/libs.tech/ngspice/osdi/r3_cmc.osdi
pre_osdi /home/ubuntu/share/pdk/ihp-sg13g2/libs.tech/ngspice/osdi/mosvar.osdi
save all
alter Vdd=1.2
tran 20p 800n
quit
.endc
.end
