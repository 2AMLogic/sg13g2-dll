* klt sim -- generated corner deck, do not edit
.lib /var/tmp/eda-job-klt-sim-2bc256fbc022/inputs/cornerMOSlv.lib mos_tt
.lib /var/tmp/eda-job-klt-sim-2bc256fbc022/inputs/cornerRES.lib res_typ
.lib /var/tmp/eda-job-klt-sim-2bc256fbc022/inputs/cornerCAP.lib cap_typ
.include /var/tmp/eda-job-klt-sim-2bc256fbc022/inputs/netlist.cir
.temp 27
.meas tran lock_max_before_220n max v(lock) from=20n to=220n
.meas tran t_rise1 when v(lock)=0.6 rise=1 td=220n
.meas tran t_fall1 when v(lock)=0.6 fall=1 td=480n
.meas tran t_rise2 when v(lock)=0.6 rise=1 td=530n
.meas tran t_edge_lock trig v(lock) val=0.12 rise=2 targ v(lock) val=1.08 rise=2
.control
pre_osdi /var/tmp/eda-job-klt-sim-2bc256fbc022/inputs/psp103.osdi
pre_osdi /var/tmp/eda-job-klt-sim-2bc256fbc022/inputs/psp103_nqs.osdi
pre_osdi /var/tmp/eda-job-klt-sim-2bc256fbc022/inputs/r3_cmc.osdi
pre_osdi /var/tmp/eda-job-klt-sim-2bc256fbc022/inputs/mosvar.osdi
save all
alter Vdd=1.2
tran 20p 800n
quit
.endc
.end
