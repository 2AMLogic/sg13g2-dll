* klt sim -- generated corner deck, do not edit
.lib /var/tmp/eda-job-klt-sim-af993ac8a260/inputs/cornerMOSlv.lib mos_ss
.lib /var/tmp/eda-job-klt-sim-af993ac8a260/inputs/cornerRES.lib res_typ
.lib /var/tmp/eda-job-klt-sim-af993ac8a260/inputs/cornerCAP.lib cap_typ
.include /var/tmp/eda-job-klt-sim-af993ac8a260/inputs/netlist.cir
.temp 125
.control
pre_osdi /var/tmp/eda-job-klt-sim-af993ac8a260/inputs/psp103.osdi
pre_osdi /var/tmp/eda-job-klt-sim-af993ac8a260/inputs/psp103_nqs.osdi
pre_osdi /var/tmp/eda-job-klt-sim-af993ac8a260/inputs/r3_cmc.osdi
pre_osdi /var/tmp/eda-job-klt-sim-af993ac8a260/inputs/mosvar.osdi
save all
alter Vdd=1.08
set filetype=ascii
tran 20p 800n
let __klt_xing_0 = v(ref)
write /var/tmp/eda-job-klt-sim-af993ac8a260/outputs/artifacts/ss_1p080V_125C/crossings_0.raw __klt_xing_0
let __klt_xing_1 = v(xdut.refd)
write /var/tmp/eda-job-klt-sim-af993ac8a260/outputs/artifacts/ss_1p080V_125C/crossings_1.raw __klt_xing_1
let __klt_xing_2 = v(xdut.s1)
write /var/tmp/eda-job-klt-sim-af993ac8a260/outputs/artifacts/ss_1p080V_125C/crossings_2.raw __klt_xing_2
let __klt_xing_3 = v(xdut.s2_n)
write /var/tmp/eda-job-klt-sim-af993ac8a260/outputs/artifacts/ss_1p080V_125C/crossings_3.raw __klt_xing_3
let __klt_xing_4 = v(xdut.still)
write /var/tmp/eda-job-klt-sim-af993ac8a260/outputs/artifacts/ss_1p080V_125C/crossings_4.raw __klt_xing_4
let __klt_xing_5 = v(xdut.good)
write /var/tmp/eda-job-klt-sim-af993ac8a260/outputs/artifacts/ss_1p080V_125C/crossings_5.raw __klt_xing_5
let __klt_xing_6 = v(xdut.q1)
write /var/tmp/eda-job-klt-sim-af993ac8a260/outputs/artifacts/ss_1p080V_125C/crossings_6.raw __klt_xing_6
let __klt_xing_7 = v(xdut.to)
write /var/tmp/eda-job-klt-sim-af993ac8a260/outputs/artifacts/ss_1p080V_125C/crossings_7.raw __klt_xing_7
let __klt_xing_8 = v(xdut.pt)
write /var/tmp/eda-job-klt-sim-af993ac8a260/outputs/artifacts/ss_1p080V_125C/crossings_8.raw __klt_xing_8
let __klt_xing_9 = v(xdut.bad)
write /var/tmp/eda-job-klt-sim-af993ac8a260/outputs/artifacts/ss_1p080V_125C/crossings_9.raw __klt_xing_9
let __klt_xing_10 = v(xdut.lockq)
write /var/tmp/eda-job-klt-sim-af993ac8a260/outputs/artifacts/ss_1p080V_125C/crossings_10.raw __klt_xing_10
let __klt_xing_11 = v(lock)
write /var/tmp/eda-job-klt-sim-af993ac8a260/outputs/artifacts/ss_1p080V_125C/crossings_11.raw __klt_xing_11
quit
.endc
.end
