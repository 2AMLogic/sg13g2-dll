* klt sim -- generated corner deck, do not edit
.lib /var/tmp/eda-job-klt-sim-e0f3decc1a82/inputs/cornerMOSlv.lib mos_ss
.lib /var/tmp/eda-job-klt-sim-e0f3decc1a82/inputs/cornerRES.lib res_typ
.lib /var/tmp/eda-job-klt-sim-e0f3decc1a82/inputs/cornerCAP.lib cap_typ
.include /var/tmp/eda-job-klt-sim-e0f3decc1a82/inputs/netlist.cir
.temp 125
.meas dc vsa_0600 find v(xdut.vsa) at=0.6
.meas dc vsb_0600 find v(xdut.vsb) at=0.6
.meas dc vsb0_0600 find v(xdut.vsb0) at=0.6
.meas dc tla_0600 find v(xdut.tla) at=0.6
.meas dc tlb_0600 find v(xdut.tlb) at=0.6
.meas dc oa_0600 find v(xdut.oa) at=0.6
.meas dc ob_0600 find v(xdut.ob) at=0.6
.meas dc still_0600 find v(still) at=0.6
.meas dc still_0585 find v(still) at=0.585
.meas dc still_0615 find v(still) at=0.615
.meas dc still_0850 find v(still) at=0.85
.meas dc vsa_0850 find v(xdut.vsa) at=0.85
.meas dc idd_0600 find i(vdd) at=0.6
.meas dc still_max_085 max v(still) from=0 to=0.85
.meas dc still_min_085 min v(still) from=0 to=0.85
.meas dc sa_0600 find v(xdut.sa) at=0.6
.meas dc sb_0600 find v(xdut.sb) at=0.6
.meas dc da_0600 find v(xdut.da) at=0.6
.meas dc ra_0600 find v(xdut.ra) at=0.6
.meas dc rb_0600 find v(xdut.rb) at=0.6
.meas dc still_0050 find v(still) at=0.05
.meas dc still_0300 find v(still) at=0.3
.meas dc still_1000 find v(still) at=1.0
.meas dc still_1315 find v(still) at=1.315
.meas dc still_max_all max v(still) from=0 to=1.32
.meas dc still_min_all min v(still) from=0 to=1.32
.meas dc sa_min_085 min v(xdut.sa) from=0 to=0.85
.meas dc sb_min_085 min v(xdut.sb) from=0 to=0.85
.control
pre_osdi /var/tmp/eda-job-klt-sim-e0f3decc1a82/inputs/psp103.osdi
pre_osdi /var/tmp/eda-job-klt-sim-e0f3decc1a82/inputs/psp103_nqs.osdi
pre_osdi /var/tmp/eda-job-klt-sim-e0f3decc1a82/inputs/r3_cmc.osdi
pre_osdi /var/tmp/eda-job-klt-sim-e0f3decc1a82/inputs/mosvar.osdi
save all
alter Vdd=1.08
dc Vctrl 0 1.32 0.005
quit
.endc
.end
