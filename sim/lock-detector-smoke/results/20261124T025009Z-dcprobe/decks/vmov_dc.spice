* sg13g2-dll :: lock_detector -- generated by design/netlist.sh from design/lock_detector.sch
* do not edit by hand; regenerate with design/netlist.sh
** sch_path: design/lock_detector.sch
.subckt lock_detector REF TAPN VCTRL LOCK VDD VSS
*.ipin REF
*.ipin TAPN
*.ipin VCTRL
*.opin LOCK
*.iopin VDD
*.iopin VSS
XD1 REF rd1 VDD VSS inv_lv
XD2 rd1 refd VDD VSS inv_lv
XT1 TAPN td1 VDD VSS inv_lv
XT2 td1 td2 VDD VSS inv_lv
XT3 td2 td3 VDD VSS inv_lv
XT4 td3 tapd VDD VSS inv_lv
XS1 TAPN refd VDD s1 s1_n VDD VSS dffr_lv
XS2 tapd refd VDD s2 s2_n VDD VSS dffr_lv
XMOV VCTRL still VDD VSS vmov_cmp
XGN s1 s2_n still bad VDD VSS nand3_lv
XGI bad good VDD VSS inv_lv
XC1 qb1 REF good q1 qb1 VDD VSS dffr_lv
XC2 qb2 qb1 good q2 qb2 VDD VSS dffr_lv
XC3 qb3 qb2 good q3 qb3 VDD VSS dffr_lv
XC4 qb4 qb3 good q4 qb4 VDD VSS dffr_lv
XC5 qb5 qb4 good q5 qb5 VDD VSS dffr_lv
XC6 qb6 qb5 good q6 qb6 VDD VSS dffr_lv
XC7 qb7 qb6 good q7 qb7 VDD VSS dffr_lv
XC8 qb8 qb7 good to qb8 VDD VSS dffr_lv
XET to pt VDD VSS edgedet
XLAT pt bad lockq lockqb VDD VSS srlatch
XO1 lockq lockn VDD VSS inv_lv
XO2 lockn LOCK VDD VSS inv2x_lv
.ends

* expanding   symbol:  inv_lv.sym # of pins=4
** sym_path: design/inv_lv.sym
** sch_path: design/inv_lv.sch
.subckt inv_lv A Y VDD VSS
*.ipin A
*.opin Y
*.iopin VDD
*.iopin VSS
XMP Y A VDD VDD sg13_lv_pmos w=1u l=0.13u ng=1 m=1
XMN Y A VSS VSS sg13_lv_nmos w=0.5u l=0.13u ng=1 m=1
.ends

* expanding   symbol:  dffr_lv.sym # of pins=7
** sym_path: design/dffr_lv.sym
** sch_path: design/dffr_lv.sch
.subckt dffr_lv D CK CLRB Q QB VDD VSS
*.ipin D
*.ipin CK
*.ipin CLRB
*.opin Q
*.opin QB
*.iopin VDD
*.iopin VSS
XIC CK ckb VDD VSS inv_lv
XID D dn VDD VSS inv_lv
XSM D ckb CLRB sm VDD VSS nand3_lv
XRM dn ckb rm VDD VSS nand2_lv
XQM sm qmb qm VDD VSS nand2_lv
XQMB rm qm CLRB qmb VDD VSS nand3_lv
XSS qm CK CLRB ss VDD VSS nand3_lv
XRS qmb CK rs VDD VSS nand2_lv
XQ ss QB Q VDD VSS nand2_lv
XQB rs Q CLRB QB VDD VSS nand3_lv
.ends

* expanding   symbol:  vmov_cmp.sym # of pins=4
** sym_path: design/vmov_cmp.sym
** sch_path: design/vmov_cmp.sch
.subckt vmov_cmp VCTRL STILL VDD VSS
*.ipin VCTRL
*.opin STILL
*.iopin VDD
*.iopin VSS
XMFA VDD VCTRL vsa VSS sg13_lv_nmos w=2u l=1u ng=1 m=1
XMSA vsa VDD VSS VSS sg13_lv_nmos w=0.5u l=1u ng=1 m=1
XMFB VDD VCTRL vsb0 VSS sg13_lv_nmos w=2u l=1u ng=1 m=1
XMSB vsb0 VDD VSS VSS sg13_lv_nmos w=0.5u l=1u ng=1 m=1
XRL1 vsb0 lp1 VSS rppd w=0.5u l=8u m=1 b=0
XRL2 lp1 lp2 VSS rppd w=0.5u l=8u m=1 b=0
XRL3 lp2 lp3 VSS rppd w=0.5u l=8u m=1 b=0
XRL4 lp3 lp4 VSS rppd w=0.5u l=8u m=1 b=0
XRL5 lp4 vsb VSS rppd w=0.5u l=8u m=1 b=0
XCL vsb VSS cap_cmim w=20u l=20u m=1
XMTA tla VSS VDD VDD sg13_lv_pmos w=1.5u l=1u ng=1 m=1
XMA1 da vsb tla VDD sg13_lv_pmos w=4u l=1u ng=1 m=1
XMA2 oa vsa tla VDD sg13_lv_pmos w=4u l=1u ng=1 m=1
XMLA1 da da VSS VSS sg13_lv_nmos w=1u l=0.5u ng=1 m=1
XMLA2 oa da VSS VSS sg13_lv_nmos w=1u l=0.5u ng=1 m=1
XMQPAR ra ra VDD VDD sg13_lv_pmos w=2u l=1u ng=1 m=1
XMQNAR ra da VSS VSS sg13_lv_nmos w=2u l=0.5u ng=1 m=1
XMQPAS sa ra VDD VDD sg13_lv_pmos w=2u l=1u ng=1 m=1
XMQNAS sa oa VSS VSS sg13_lv_nmos w=1.6u l=0.5u ng=1 m=1
XMTB tlb VSS VDD VDD sg13_lv_pmos w=1.5u l=1u ng=1 m=1
XMB1 db vsa tlb VDD sg13_lv_pmos w=4u l=1u ng=1 m=1
XMB2 ob vsb tlb VDD sg13_lv_pmos w=4u l=1u ng=1 m=1
XMLB1 db db VSS VSS sg13_lv_nmos w=1u l=0.5u ng=1 m=1
XMLB2 ob db VSS VSS sg13_lv_nmos w=1u l=0.5u ng=1 m=1
XMQPBR rb rb VDD VDD sg13_lv_pmos w=2u l=1u ng=1 m=1
XMQNBR rb db VSS VSS sg13_lv_nmos w=2u l=0.5u ng=1 m=1
XMQPBS sb rb VDD VDD sg13_lv_pmos w=2u l=1u ng=1 m=1
XMQNBS sb ob VSS VSS sg13_lv_nmos w=1.6u l=0.5u ng=1 m=1
XSN sa sb still_n VDD VSS nand2_lv
XSI still_n STILL VDD VSS inv_lv
.ends

* expanding   symbol:  nand3_lv.sym # of pins=6
** sym_path: design/nand3_lv.sym
** sch_path: design/nand3_lv.sch
.subckt nand3_lv A1 A2 A3 Y VDD VSS
*.ipin A1
*.ipin A2
*.ipin A3
*.opin Y
*.iopin VDD
*.iopin VSS
XMP1 Y A1 VDD VDD sg13_lv_pmos w=1u l=0.13u ng=1 m=1
XMP2 Y A2 VDD VDD sg13_lv_pmos w=1u l=0.13u ng=1 m=1
XMP3 Y A3 VDD VDD sg13_lv_pmos w=1u l=0.13u ng=1 m=1
XMN1 Y A1 m1 VSS sg13_lv_nmos w=1.5u l=0.13u ng=1 m=1
XMN2 m1 A2 m2 VSS sg13_lv_nmos w=1.5u l=0.13u ng=1 m=1
XMN3 m2 A3 VSS VSS sg13_lv_nmos w=1.5u l=0.13u ng=1 m=1
.ends

* expanding   symbol:  edgedet.sym # of pins=4
** sym_path: design/edgedet.sym
** sch_path: design/edgedet.sch
.subckt edgedet X OUT VDD VSS
*.ipin X
*.opin OUT
*.iopin VDD
*.iopin VSS
XMPD1 d1 X VDD VDD sg13_lv_pmos w=1u l=0.16u ng=1 m=1
XMND1 d1 X VSS VSS sg13_lv_nmos w=0.5u l=0.16u ng=1 m=1
XMPD2 d2 d1 VDD VDD sg13_lv_pmos w=1u l=0.16u ng=1 m=1
XMND2 d2 d1 VSS VSS sg13_lv_nmos w=0.5u l=0.16u ng=1 m=1
XMPD3 d3 d2 VDD VDD sg13_lv_pmos w=1u l=0.16u ng=1 m=1
XMND3 d3 d2 VSS VSS sg13_lv_nmos w=0.5u l=0.16u ng=1 m=1
XN1 X d3 ntmp VDD VSS nand2_lv
XOUT ntmp OUT VDD VSS inv_lv
.ends

* expanding   symbol:  srlatch.sym # of pins=6
** sym_path: design/srlatch.sym
** sch_path: design/srlatch.sch
.subckt srlatch S R Q QB VDD VSS
*.ipin S
*.ipin R
*.opin Q
*.opin QB
*.iopin VDD
*.iopin VSS
XIS S SB VDD VSS inv_lv
XIR R RB VDD VSS inv_lv
XNQ SB QB Q VDD VSS nand2_lv
XNQB RB Q QB VDD VSS nand2_lv
.ends

* expanding   symbol:  inv2x_lv.sym # of pins=4
** sym_path: design/inv2x_lv.sym
** sch_path: design/inv2x_lv.sch
.subckt inv2x_lv A Y VDD VSS
*.ipin A
*.opin Y
*.iopin VDD
*.iopin VSS
XMP Y A VDD VDD sg13_lv_pmos w=2u l=0.13u ng=1 m=1
XMN Y A VSS VSS sg13_lv_nmos w=1u l=0.13u ng=1 m=1
.ends

* expanding   symbol:  nand2_lv.sym # of pins=5
** sym_path: design/nand2_lv.sym
** sch_path: design/nand2_lv.sch
.subckt nand2_lv A1 A2 Y VDD VSS
*.ipin A1
*.ipin A2
*.opin Y
*.iopin VDD
*.iopin VSS
XMP1 Y A1 VDD VDD sg13_lv_pmos w=1u l=0.13u ng=1 m=1
XMP2 Y A2 VDD VDD sg13_lv_pmos w=1u l=0.13u ng=1 m=1
XMN1 Y A1 mid VSS sg13_lv_nmos w=1u l=0.13u ng=1 m=1
XMN2 mid A2 VSS VSS sg13_lv_nmos w=1u l=0.13u ng=1 m=1
.ends

* vmov_cmp standalone DC probe body (issue #189, the lock-detector half of the
* #145/#148 ss diagnosis). Deck = design/netlist/lock_detector.spice (the
* committed export; vmov_cmp and its siblings used verbatim) + this body.
* Not a design.
* Question: does the VCTRL-movement sensor have a valid DC operating point and
* a STILL=1 quiet window at each reduced-set corner, and where do its outputs
* flip as VCTRL -- the OTA pair's common-mode input; in DC the low-pass cap is
* open so vsb = vsb0 = vsa by construction -- is swept 0..1.32 V at 5 mV? The
* smoke stimulus's quiet VCTRL is 0.600 V with +-15 mV of ripple (0.585..0.615
* V), below the documented ~0.85 V validity ceiling (design/NOTES.md "Lock
* detector"). Transitions are identified where each output crosses 50 % of the
* corner's own rail (the v(half) node), never a per-corner literal, so the one
* request grades every corner. The OTA tail currents cannot be carried by any
* klt sim measurement form as shipped (OSDI @m instance vectors save but never
* print; 2AMLogic/klayout-tools#6997): the block's total supply current
* i(vdd) and the internal node voltages (vsa, vsb, tla, tlb, oa, ob, oab,
* obb) are recorded instead. Results are simulated, never measured.
Vdd vdd 0 1.2
Vctrl vctrl 0 DC 0.6
Bhalf half 0 V = 0.5*v(vdd)
XDUT vctrl still vdd 0 vmov_cmp
