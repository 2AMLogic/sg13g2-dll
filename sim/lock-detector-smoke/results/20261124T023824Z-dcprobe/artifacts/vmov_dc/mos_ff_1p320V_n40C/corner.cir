* klt sim -- generated corner deck, do not edit
.lib /var/tmp/eda-job-klt-sim-cbe007fbe062/inputs/cornerMOSlv.lib mos_ff
.lib /var/tmp/eda-job-klt-sim-cbe007fbe062/inputs/cornerRES.lib res_typ
.lib /var/tmp/eda-job-klt-sim-cbe007fbe062/inputs/cornerCAP.lib cap_typ
.include /var/tmp/eda-job-klt-sim-cbe007fbe062/inputs/netlist.cir
.temp -40
.meas dc vsa_0600 find v(xdut.vsa) at=0.6
.meas dc vsb_0600 find v(xdut.vsb) at=0.6
.meas dc vsb0_0600 find v(xdut.vsb0) at=0.6
.meas dc tla_0600 find v(xdut.tla) at=0.6
.meas dc tlb_0600 find v(xdut.tlb) at=0.6
.meas dc oa_0600 find v(xdut.oa) at=0.6
.meas dc ob_0600 find v(xdut.ob) at=0.6
.meas dc still_0600 find v(still) at=0.6
.meas dc still_0585 find v(still) at=0.585
.meas dc still_0615 find v(still) at=0.615
.meas dc still_0850 find v(still) at=0.85
.meas dc vsa_0850 find v(xdut.vsa) at=0.85
.meas dc idd_0600 find i(vdd) at=0.6
.meas dc still_max_085 max v(still) from=0 to=0.85
.meas dc still_min_085 min v(still) from=0 to=0.85
.meas dc still_r1 when v(still)=v(half) rise=1
.meas dc still_f1 when v(still)=v(half) fall=1
.meas dc sa_0600 find v(xdut.sa) at=0.6
.meas dc sb_0600 find v(xdut.sb) at=0.6
.meas dc da_0600 find v(xdut.da) at=0.6
.meas dc ra_0600 find v(xdut.ra) at=0.6
.meas dc rb_0600 find v(xdut.rb) at=0.6
.meas dc sa_f1 when v(xdut.sa)=v(half) fall=1
.meas dc sa_r1 when v(xdut.sa)=v(half) rise=1
.meas dc sb_f1 when v(xdut.sb)=v(half) fall=1
.meas dc sb_r1 when v(xdut.sb)=v(half) rise=1
.control
pre_osdi /var/tmp/eda-job-klt-sim-cbe007fbe062/inputs/psp103.osdi
pre_osdi /var/tmp/eda-job-klt-sim-cbe007fbe062/inputs/psp103_nqs.osdi
pre_osdi /var/tmp/eda-job-klt-sim-cbe007fbe062/inputs/r3_cmc.osdi
pre_osdi /var/tmp/eda-job-klt-sim-cbe007fbe062/inputs/mosvar.osdi
save all
alter Vdd=1.32
dc Vctrl 0 1.32 0.005
quit
.endc
.end
