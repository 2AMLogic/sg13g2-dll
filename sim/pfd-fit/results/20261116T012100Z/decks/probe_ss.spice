* sg13g2-dll sim/pfd-fit probe (probe_ss, issue #140 candidate): single-corner diagnostic,
* ss/1.08 V/125 C, of the srlatch_buf candidate of spec/decisions/0015 (buffered lane output,
* reset NAND on the internal storage nodes). Deck stimulus byte-identical to pfd_1g.spice
* (FB-minus-REF offset per cycle (ps), cycle 0 first: 0 0 0 -160 -80 -40 -20 -10 -5 0 5 10 20 40 80 160 0 0 0); the DUT is pfd_buf, defined inline here, wiring the committed
* edgedet/nand2x_lv/inv4x_lv (from the pfd.spice copy next to this deck) around srlatch_buf.
* srlatch_buf below is the `klt netlist design/srlatch_buf.sch --block` export of the
* cells.py cell, inlined verbatim. pfd.sch itself is untouched (not ratified yet).
* Run locally through `klt sim` (single unit, --backend local). Simulated, never measured.
Vdd vdd 0 1.2
.include "pfd.spice"

* --- candidate cell (generated, inlined; see header) ---
.subckt srlatch_buf S R Q QB QN VDD VSS
*.ipin S
*.ipin R
*.opin Q
*.opin QB
*.opin QN
*.iopin VDD
*.iopin VSS
XIS S SB VDD VSS inv2x_lv
XIR R RB VDD VSS inv4x_lv
XMPQ1 QN SB VDD VDD sg13_lv_pmos w=4u l=0.13u ng=1 m=1
XMPQ2 QN QB VDD VDD sg13_lv_pmos w=4u l=0.13u ng=1 m=1
XMNQ1 QN SB midq VSS sg13_lv_nmos w=4u l=0.13u ng=1 m=1
XMNQ2 midq QB VSS VSS sg13_lv_nmos w=4u l=0.13u ng=1 m=1
XMPB1 QB RB VDD VDD sg13_lv_pmos w=4u l=0.13u ng=1 m=1
XMPB2 QB QN VDD VDD sg13_lv_pmos w=4u l=0.13u ng=1 m=1
XMNB1 QB RB midb VSS sg13_lv_nmos w=4u l=0.13u ng=1 m=1
XMNB2 midb QN VSS VSS sg13_lv_nmos w=4u l=0.13u ng=1 m=1
XOQ QB Q VDD VSS inv4x_lv
.ends
* --- candidate PFD: same topology as pfd, latch = srlatch_buf, reset NAND taps QN ---
.subckt pfd_buf REF FB UP DN VDD VSS
XED_UP REF set_up VDD VSS edgedet
XED_DN FB set_dn VDD VSS edgedet
XLU set_up reset UP up_qb up_qn VDD VSS srlatch_buf
XLD set_dn reset DN dn_qb dn_qn VDD VSS srlatch_buf
XNR up_qn dn_qn reset_n0 VDD VSS nand2x_lv
XR1 reset_n0 reset VDD VSS inv4x_lv
.ends
Vrefn refn 0 PWL(0.0000n 0 4.9500n 0 5.0500n 1 5.4500n 1 5.5500n 0 5.9500n 0 6.0500n 1 6.4500n 1 6.5500n 0 6.9500n 0 7.0500n 1 7.4500n 1 7.5500n 0 7.9500n 0 8.0500n 1 8.4500n 1 8.5500n 0 8.9500n 0 9.0500n 1 9.4500n 1 9.5500n 0 9.9500n 0 10.0500n 1 10.4500n 1 10.5500n 0 10.9500n 0 11.0500n 1 11.4500n 1 11.5500n 0 11.9500n 0 12.0500n 1 12.4500n 1 12.5500n 0 12.9500n 0 13.0500n 1 13.4500n 1 13.5500n 0 13.9500n 0 14.0500n 1 14.4500n 1 14.5500n 0 14.9500n 0 15.0500n 1 15.4500n 1 15.5500n 0 15.9500n 0 16.0500n 1 16.4500n 1 16.5500n 0 16.9500n 0 17.0500n 1 17.4500n 1 17.5500n 0 17.9500n 0 18.0500n 1 18.4500n 1 18.5500n 0 18.9500n 0 19.0500n 1 19.4500n 1 19.5500n 0 19.9500n 0 20.0500n 1 20.4500n 1 20.5500n 0 20.9500n 0 21.0500n 1 21.4500n 1 21.5500n 0 21.9500n 0 22.0500n 1 22.4500n 1 22.5500n 0 22.9500n 0 23.0500n 1 23.4500n 1 23.5500n 0)
Vfbn fbn 0 PWL(0.0000n 0 4.9500n 0 5.0500n 1 5.4500n 1 5.5500n 0 5.9500n 0 6.0500n 1 6.4500n 1 6.5500n 0 6.9500n 0 7.0500n 1 7.4500n 1 7.5500n 0 7.7900n 0 7.8900n 1 8.2900n 1 8.3900n 0 8.8700n 0 8.9700n 1 9.3700n 1 9.4700n 0 9.9100n 0 10.0100n 1 10.4100n 1 10.5100n 0 10.9300n 0 11.0300n 1 11.4300n 1 11.5300n 0 11.9400n 0 12.0400n 1 12.4400n 1 12.5400n 0 12.9450n 0 13.0450n 1 13.4450n 1 13.5450n 0 13.9500n 0 14.0500n 1 14.4500n 1 14.5500n 0 14.9550n 0 15.0550n 1 15.4550n 1 15.5550n 0 15.9600n 0 16.0600n 1 16.4600n 1 16.5600n 0 16.9700n 0 17.0700n 1 17.4700n 1 17.5700n 0 17.9900n 0 18.0900n 1 18.4900n 1 18.5900n 0 19.0300n 0 19.1300n 1 19.5300n 1 19.6300n 0 20.1100n 0 20.2100n 1 20.6100n 1 20.7100n 0 20.9500n 0 21.0500n 1 21.4500n 1 21.5500n 0 21.9500n 0 22.0500n 1 22.4500n 1 22.5500n 0 22.9500n 0 23.0500n 1 23.4500n 1 23.5500n 0)
Bref ref 0 V = v(vdd)*v(refn)
Bfb fb 0 V = v(vdd)*v(fbn)
Cup up 0 4e-15
Cdn dn 0 4e-15
Xdut ref fb up dn vdd 0 pfd_buf
