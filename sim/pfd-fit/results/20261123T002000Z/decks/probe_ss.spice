* sg13g2-dll sim/pfd-fit probe (probe_ss, issue #151 reconciliation): single-corner diagnostic,
* ss/1.08 V/125 C, of the committed design/netlist/pfd.spice after the srlatch_buf
* rewire (spec/decisions/0015, issue #151). Deck stimulus byte-identical to
* sim/pfd-fit/decks/pfd_1g.spice (same Vrefn/Vfbn PWL lines, same 4 fF Cup/Cdn bench
* loads); the DUT is the committed pfd subckt itself, not a deck-inline copy - this
* is the probe-vs-gate caveat of issue #151: the retained 20261116T012100Z probe ran
* the candidate unwired (deck-inline pfd_buf), so this run re-measures path/release/width
* on the in-pfd netlist (hierarchy/parasitic naming is the only difference allowed).
* Run locally through klt sim (single unit, --backend local). Simulated, never measured.
Vdd vdd 0 1.2
.include "pfd.spice"
Vrefn refn 0 PWL(0.0000n 0 4.9500n 0 5.0500n 1 5.4500n 1 5.5500n 0 5.9500n 0 6.0500n 1 6.4500n 1 6.5500n 0 6.9500n 0 7.0500n 1 7.4500n 1 7.5500n 0 7.9500n 0 8.0500n 1 8.4500n 1 8.5500n 0 8.9500n 0 9.0500n 1 9.4500n 1 9.5500n 0 9.9500n 0 10.0500n 1 10.4500n 1 10.5500n 0 10.9500n 0 11.0500n 1 11.4500n 1 11.5500n 0 11.9500n 0 12.0500n 1 12.4500n 1 12.5500n 0 12.9500n 0 13.0500n 1 13.4500n 1 13.5500n 0 13.9500n 0 14.0500n 1 14.4500n 1 14.5500n 0 14.9500n 0 15.0500n 1 15.4500n 1 15.5500n 0 15.9500n 0 16.0500n 1 16.4500n 1 16.5500n 0 16.9500n 0 17.0500n 1 17.4500n 1 17.5500n 0 17.9500n 0 18.0500n 1 18.4500n 1 18.5500n 0 18.9500n 0 19.0500n 1 19.4500n 1 19.5500n 0 19.9500n 0 20.0500n 1 20.4500n 1 20.5500n 0 20.9500n 0 21.0500n 1 21.4500n 1 21.5500n 0 21.9500n 0 22.0500n 1 22.4500n 1 22.5500n 0 22.9500n 0 23.0500n 1 23.4500n 1 23.5500n 0)
Vfbn fbn 0 PWL(0.0000n 0 4.9500n 0 5.0500n 1 5.4500n 1 5.5500n 0 5.9500n 0 6.0500n 1 6.4500n 1 6.5500n 0 6.9500n 0 7.0500n 1 7.4500n 1 7.5500n 0 7.7900n 0 7.8900n 1 8.2900n 1 8.3900n 0 8.8700n 0 8.9700n 1 9.3700n 1 9.4700n 0 9.9100n 0 10.0100n 1 10.4100n 1 10.5100n 0 10.9300n 0 11.0300n 1 11.4300n 1 11.5300n 0 11.9400n 0 12.0400n 1 12.4400n 1 12.5400n 0 12.9450n 0 13.0450n 1 13.4450n 1 13.5450n 0 13.9500n 0 14.0500n 1 14.4500n 1 14.5500n 0 14.9550n 0 15.0550n 1 15.4550n 1 15.5550n 0 15.9600n 0 16.0600n 1 16.4600n 1 16.5600n 0 16.9700n 0 17.0700n 1 17.4700n 1 17.5700n 0 17.9900n 0 18.0900n 1 18.4900n 1 18.5900n 0 19.0300n 0 19.1300n 1 19.5300n 1 19.6300n 0 20.1100n 0 20.2100n 1 20.6100n 1 20.7100n 0 20.9500n 0 21.0500n 1 21.4500n 1 21.5500n 0 21.9500n 0 22.0500n 1 22.4500n 1 22.5500n 0 22.9500n 0 23.0500n 1 23.4500n 1 23.5500n 0)
Bref ref 0 V = v(vdd)*v(refn)
Bfb fb 0 V = v(vdd)*v(fbn)
Xdut ref fb up dn vdd 0 pfd
Cup up 0 4e-15
Cdn dn 0 4e-15
