* klt sim -- generated corner deck, do not edit
.lib /home/ubuntu/share/pdk/ihp-sg13g2/libs.tech/ngspice/models/cornerMOSlv.lib mos_ss
.include /home/ubuntu/GitHub/sg13g2-dll/.loom/worktrees/issue-113/sim/pfd-fit/results/20261115T081500Z/requests/../decks/probe_ss.spice
.temp 125
.control
pre_osdi /home/ubuntu/share/pdk/ihp-sg13g2/libs.tech/ngspice/osdi/psp103.osdi
pre_osdi /home/ubuntu/share/pdk/ihp-sg13g2/libs.tech/ngspice/osdi/psp103_nqs.osdi
pre_osdi /home/ubuntu/share/pdk/ihp-sg13g2/libs.tech/ngspice/osdi/r3_cmc.osdi
pre_osdi /home/ubuntu/share/pdk/ihp-sg13g2/libs.tech/ngspice/osdi/mosvar.osdi
save all
alter Vdd=1.08
set filetype=ascii
tran 5p 25.000n
let __klt_xing_0 = v(ref)
write /home/ubuntu/GitHub/sg13g2-dll/.loom/worktrees/issue-113/sim/pfd-fit/results/20261115T081500Z/artifacts/probe_ss/mos_ss_1p080V_125C/crossings_0.raw __klt_xing_0
let __klt_xing_1 = v(fb)
write /home/ubuntu/GitHub/sg13g2-dll/.loom/worktrees/issue-113/sim/pfd-fit/results/20261115T081500Z/artifacts/probe_ss/mos_ss_1p080V_125C/crossings_1.raw __klt_xing_1
let __klt_xing_2 = v(up)
write /home/ubuntu/GitHub/sg13g2-dll/.loom/worktrees/issue-113/sim/pfd-fit/results/20261115T081500Z/artifacts/probe_ss/mos_ss_1p080V_125C/crossings_2.raw __klt_xing_2
let __klt_xing_3 = v(dn)
write /home/ubuntu/GitHub/sg13g2-dll/.loom/worktrees/issue-113/sim/pfd-fit/results/20261115T081500Z/artifacts/probe_ss/mos_ss_1p080V_125C/crossings_3.raw __klt_xing_3
let __klt_xing_4 = v(xdut.set_up)
write /home/ubuntu/GitHub/sg13g2-dll/.loom/worktrees/issue-113/sim/pfd-fit/results/20261115T081500Z/artifacts/probe_ss/mos_ss_1p080V_125C/crossings_4.raw __klt_xing_4
let __klt_xing_5 = v(xdut.set_dn)
write /home/ubuntu/GitHub/sg13g2-dll/.loom/worktrees/issue-113/sim/pfd-fit/results/20261115T081500Z/artifacts/probe_ss/mos_ss_1p080V_125C/crossings_5.raw __klt_xing_5
let __klt_xing_6 = v(xdut.reset)
write /home/ubuntu/GitHub/sg13g2-dll/.loom/worktrees/issue-113/sim/pfd-fit/results/20261115T081500Z/artifacts/probe_ss/mos_ss_1p080V_125C/crossings_6.raw __klt_xing_6
quit
.endc
.end
