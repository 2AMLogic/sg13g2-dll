* klt sim -- generated corner deck, do not edit
.lib /var/tmp/eda-job-klt-sim-7bcf2ffe475f/inputs/cornerMOSlv.lib mos_ff
.include /var/tmp/eda-job-klt-sim-7bcf2ffe475f/inputs/netlist.cir
.temp -40
.control
pre_osdi /var/tmp/eda-job-klt-sim-7bcf2ffe475f/inputs/psp103.osdi
pre_osdi /var/tmp/eda-job-klt-sim-7bcf2ffe475f/inputs/psp103_nqs.osdi
pre_osdi /var/tmp/eda-job-klt-sim-7bcf2ffe475f/inputs/r3_cmc.osdi
pre_osdi /var/tmp/eda-job-klt-sim-7bcf2ffe475f/inputs/mosvar.osdi
save all
alter Vdd=1.32
set filetype=ascii
tran 5p 45.000n
let __klt_xing_0 = v(ref)
write /var/tmp/eda-job-klt-sim-7bcf2ffe475f/outputs/artifacts/mos_ff_1p320V_n40C/crossings_0.raw __klt_xing_0
let __klt_xing_1 = v(fb)
write /var/tmp/eda-job-klt-sim-7bcf2ffe475f/outputs/artifacts/mos_ff_1p320V_n40C/crossings_1.raw __klt_xing_1
let __klt_xing_2 = v(up)
write /var/tmp/eda-job-klt-sim-7bcf2ffe475f/outputs/artifacts/mos_ff_1p320V_n40C/crossings_2.raw __klt_xing_2
let __klt_xing_3 = v(dn)
write /var/tmp/eda-job-klt-sim-7bcf2ffe475f/outputs/artifacts/mos_ff_1p320V_n40C/crossings_3.raw __klt_xing_3
quit
.endc
.end
