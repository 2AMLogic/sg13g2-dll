* sg13g2-dll sim/pfd-fit: 0006 PFD fit gate, 500 MHz.
* Generated by sim/pfd-fit/make_bench.py. klt sim netlist body: no .lib/.temp/analysis/.end.
* pfd.spice is design/netlist/pfd.spice, copied next to this deck by run.sh.
* FB-minus-REF offset per cycle (ps), cycle 0 first: 0 0 0 -160 -80 -40 -20 -10 -5 0 5 10 20 40 80 160 0 0 0
Vdd vdd 0 1.2
.include "pfd.spice"
Vrefn refn 0 PWL(0.0000n 0 4.9500n 0 5.0500n 1 5.9500n 1 6.0500n 0 6.9500n 0 7.0500n 1 7.9500n 1 8.0500n 0 8.9500n 0 9.0500n 1 9.9500n 1 10.0500n 0 10.9500n 0 11.0500n 1 11.9500n 1 12.0500n 0 12.9500n 0 13.0500n 1 13.9500n 1 14.0500n 0 14.9500n 0 15.0500n 1 15.9500n 1 16.0500n 0 16.9500n 0 17.0500n 1 17.9500n 1 18.0500n 0 18.9500n 0 19.0500n 1 19.9500n 1 20.0500n 0 20.9500n 0 21.0500n 1 21.9500n 1 22.0500n 0 22.9500n 0 23.0500n 1 23.9500n 1 24.0500n 0 24.9500n 0 25.0500n 1 25.9500n 1 26.0500n 0 26.9500n 0 27.0500n 1 27.9500n 1 28.0500n 0 28.9500n 0 29.0500n 1 29.9500n 1 30.0500n 0 30.9500n 0 31.0500n 1 31.9500n 1 32.0500n 0 32.9500n 0 33.0500n 1 33.9500n 1 34.0500n 0 34.9500n 0 35.0500n 1 35.9500n 1 36.0500n 0 36.9500n 0 37.0500n 1 37.9500n 1 38.0500n 0 38.9500n 0 39.0500n 1 39.9500n 1 40.0500n 0 40.9500n 0 41.0500n 1 41.9500n 1 42.0500n 0)
Vfbn fbn 0 PWL(0.0000n 0 4.9500n 0 5.0500n 1 5.9500n 1 6.0500n 0 6.9500n 0 7.0500n 1 7.9500n 1 8.0500n 0 8.9500n 0 9.0500n 1 9.9500n 1 10.0500n 0 10.7900n 0 10.8900n 1 11.7900n 1 11.8900n 0 12.8700n 0 12.9700n 1 13.8700n 1 13.9700n 0 14.9100n 0 15.0100n 1 15.9100n 1 16.0100n 0 16.9300n 0 17.0300n 1 17.9300n 1 18.0300n 0 18.9400n 0 19.0400n 1 19.9400n 1 20.0400n 0 20.9450n 0 21.0450n 1 21.9450n 1 22.0450n 0 22.9500n 0 23.0500n 1 23.9500n 1 24.0500n 0 24.9550n 0 25.0550n 1 25.9550n 1 26.0550n 0 26.9600n 0 27.0600n 1 27.9600n 1 28.0600n 0 28.9700n 0 29.0700n 1 29.9700n 1 30.0700n 0 30.9900n 0 31.0900n 1 31.9900n 1 32.0900n 0 33.0300n 0 33.1300n 1 34.0300n 1 34.1300n 0 35.1100n 0 35.2100n 1 36.1100n 1 36.2100n 0 36.9500n 0 37.0500n 1 37.9500n 1 38.0500n 0 38.9500n 0 39.0500n 1 39.9500n 1 40.0500n 0 40.9500n 0 41.0500n 1 41.9500n 1 42.0500n 0)
Bref ref 0 V = v(vdd)*v(refn)
Bfb fb 0 V = v(vdd)*v(fbn)
Xdut ref fb up dn vdd 0 pfd
Cup up 0 4e-15
Cdn dn 0 4e-15
