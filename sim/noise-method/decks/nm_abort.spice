* noise-method abort probe: PULSE drive + trnoise equivalent (0014).
* The trnoise amplitude below is arbitrary: the probe exists to abort, not to
* calibrate -- do not treat 6.729066e-08 as a sized equivalent.
Vdd vdd 0 1.2
Vin gin 0 PULSE(0 1.2 0.2n 50p 50p 1.8n 4n)
Vn gin in 0 dc=0 trnoise(6.729066e-08 1p)
XMP out in vdd vdd sg13_lv_pmos w=0.15u l=0.13u ng=1 m=1
XMN out in 0 0 sg13_lv_nmos w=0.15u l=0.13u ng=1 m=1
Cl out 0 2f
