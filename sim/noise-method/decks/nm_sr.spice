* noise-method known case: slew rate at the OP, noiseless (0014)
Vdd vdd 0 1.2
Vin in 0 PULSE(0 1.2 0.2n 50p 50p 1.8n 4n)
XMP out in vdd vdd sg13_lv_pmos w=0.15u l=0.13u ng=1 m=1
XMN out in 0 0 sg13_lv_nmos w=0.15u l=0.13u ng=1 m=1
Cl out 0 2f
