* noise-method known case: ENBW identity, 1M series reference resistor (0014)
Vdd vdd 0 1.2
Vin gin 0 0.570258 ac 1
Rref gin in 1Meg
XMP out in vdd vdd sg13_lv_pmos w=0.15u l=0.13u ng=1 m=1
XMN out in 0 0 sg13_lv_nmos w=0.15u l=0.13u ng=1 m=1
Cl out 0 2f
