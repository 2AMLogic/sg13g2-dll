* klt sim -- generated corner deck, do not edit
.lib /var/tmp/eda-job-klt-sim-b433ec88f70e/inputs/cornerMOSlv.lib mos_ff
.include /var/tmp/eda-job-klt-sim-b433ec88f70e/inputs/netlist.cir
.temp -40
.meas tran dr1 trig v(t0) val=0.66 rise=1 targ v(t1) val=0.66 rise=1
.meas tran df1 trig v(t0) val=0.66 fall=1 targ v(t1) val=0.66 fall=1
.meas tran dr2 trig v(t0) val=0.66 rise=1 targ v(t2) val=0.66 rise=1
.meas tran df2 trig v(t0) val=0.66 fall=1 targ v(t2) val=0.66 fall=1
.meas tran dr3 trig v(t0) val=0.66 rise=1 targ v(t3) val=0.66 rise=1
.meas tran df3 trig v(t0) val=0.66 fall=1 targ v(t3) val=0.66 fall=1
.meas tran dr4 trig v(t0) val=0.66 rise=1 targ v(t4) val=0.66 rise=1
.meas tran df4 trig v(t0) val=0.66 fall=1 targ v(t4) val=0.66 fall=1
.meas tran dr5 trig v(t0) val=0.66 rise=1 targ v(t5) val=0.66 rise=1
.meas tran df5 trig v(t0) val=0.66 fall=1 targ v(t5) val=0.66 fall=1
.meas tran dr6 trig v(t0) val=0.66 rise=1 targ v(t6) val=0.66 rise=1
.meas tran df6 trig v(t0) val=0.66 fall=1 targ v(t6) val=0.66 fall=1
.meas tran dr7 trig v(t0) val=0.66 rise=1 targ v(t7) val=0.66 rise=1
.meas tran df7 trig v(t0) val=0.66 fall=1 targ v(t7) val=0.66 fall=1
.meas tran dr8 trig v(t0) val=0.66 rise=1 targ v(t8) val=0.66 rise=1
.meas tran df8 trig v(t0) val=0.66 fall=1 targ v(t8) val=0.66 fall=1
.meas tran iavg avg i(Vdd) from=6n to=10n
.control
pre_osdi /var/tmp/eda-job-klt-sim-b433ec88f70e/inputs/psp103.osdi
pre_osdi /var/tmp/eda-job-klt-sim-b433ec88f70e/inputs/psp103_nqs.osdi
pre_osdi /var/tmp/eda-job-klt-sim-b433ec88f70e/inputs/r3_cmc.osdi
pre_osdi /var/tmp/eda-job-klt-sim-b433ec88f70e/inputs/mosvar.osdi
save all
alter VC=0.3
alter Vdd=1.32
tran 5p 10n
quit
.endc
.end
