* klt sim -- generated corner deck, do not edit
.options seed=2000673943
.param mc_sample_index=6
.param mc_process_seed=1022315396
.param mc_mismatch_seed=240619691
.lib /var/tmp/eda-job-klt-sim-c6460b1aa0b1/inputs/cornerMOSlv.lib mos_ss_mismatch
.include /var/tmp/eda-job-klt-sim-c6460b1aa0b1/inputs/netlist.cir
.temp 27
.meas tran voh find v(out) at=0.9n
.meas tran vol find v(out) at=2.0n
.meas tran tphl trig v(in) val=0.6 rise=1 targ v(out) val=0.6 fall=1
.meas tran tplh trig v(in) val=0.6 fall=1 targ v(out) val=0.6 rise=1
.control
pre_osdi /var/tmp/eda-job-klt-sim-c6460b1aa0b1/inputs/psp103.osdi
pre_osdi /var/tmp/eda-job-klt-sim-c6460b1aa0b1/inputs/psp103_nqs.osdi
pre_osdi /var/tmp/eda-job-klt-sim-c6460b1aa0b1/inputs/r3_cmc.osdi
pre_osdi /var/tmp/eda-job-klt-sim-c6460b1aa0b1/inputs/mosvar.osdi
save all
tran 5p 6n
quit
.endc
.end
