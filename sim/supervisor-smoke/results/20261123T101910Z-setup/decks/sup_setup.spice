* sg13g2-dll :: supervisor -- generated by design/netlist.sh from design/supervisor.sch
* do not edit by hand; regenerate with design/netlist.sh
** sch_path: design/supervisor.sch
.subckt supervisor REF TAPN TAPH EN VCTRL REFM RST VDD VSS
*.ipin REF
*.ipin TAPN
*.ipin TAPH
*.ipin EN
*.iopin VCTRL
*.opin REFM
*.opin RST
*.iopin VDD
*.iopin VSS
XWIN REF TAPN TAPH over VDD VSS win_det
XRAIL VCTRL nhi nlo near VDD VSS rail_cmp
XCN near RSTB cnt_clr_n VDD VSS nand2_lv
XCI cnt_clr_n cnt_en VDD VSS inv_lv
XCNT REF cnt_en to VDD VSS timeout_cnt
XET to pt VDD VSS edgedet
XIPO over over_n VDD VSS inv_lv
XIPT pt pt_n VDD VSS inv_lv
XSET over_n pt_n EN set VDD VSS nand3_lv
XISB set set_n VDD VSS inv_lv
XRN nhi set_n clr_n VDD VSS nand2_lv
XRI clr_n clr VDD VSS inv_lv
XLAT set clr RST RSTB VDD VSS srlatch
XMRST VCTRL RSTB VDD VDD sg13_lv_pmos w=20u l=0.13u ng=1 m=1
XMSK REF RSTB REFM VDD VSS refmask
.ends

* expanding   symbol:  win_det.sym # of pins=6
** sym_path: design/win_det.sym
** sch_path: design/win_det.sch
.subckt win_det REF TAPN TAPH OVER VDD VSS
*.ipin REF
*.ipin TAPN
*.ipin TAPH
*.opin OVER
*.iopin VDD
*.iopin VSS
XIREF REF refb VDD VSS inv_lv
XAUP TAPN REF VDD a_up a_up_n VDD VSS dffr_lv
XADN TAPN refb VDD a_dn a_dn_n VDD VSS dffr_lv
XBUP TAPH REF VDD b_up b_up_n VDD VSS dffr_fast
XNO b_up a_up a_dn_n over_n VDD VSS nand3_lv
XIO over_n OVER VDD VSS inv_lv
.ends

* expanding   symbol:  rail_cmp.sym # of pins=6
** sym_path: design/rail_cmp.sym
** sch_path: design/rail_cmp.sch
.subckt rail_cmp VCTRL NHI NLO NEAR VDD VSS
*.ipin VCTRL
*.opin NHI
*.opin NLO
*.opin NEAR
*.iopin VDD
*.iopin VSS
XRA VDD refh VSS rppd w=0.5u l=8u m=1 b=0
XRB1 refh lad1 VSS rppd w=0.5u l=8u m=1 b=0
XRB2 lad1 lad2 VSS rppd w=0.5u l=8u m=1 b=0
XRB3 lad2 lad3 VSS rppd w=0.5u l=8u m=1 b=0
XRB4 lad3 lad4 VSS rppd w=0.5u l=8u m=1 b=0
XRB5 lad4 lad5 VSS rppd w=0.5u l=8u m=1 b=0
XRB6 lad5 lad6 VSS rppd w=0.5u l=8u m=1 b=0
XRB7 lad6 lad7 VSS rppd w=0.5u l=8u m=1 b=0
XRB8 lad7 lad8 VSS rppd w=0.5u l=8u m=1 b=0
XRB9 lad8 lad9 VSS rppd w=0.5u l=8u m=1 b=0
XRB10 lad9 lad10 VSS rppd w=0.5u l=8u m=1 b=0
XRB11 lad10 lad11 VSS rppd w=0.5u l=8u m=1 b=0
XRB12 lad11 lad12 VSS rppd w=0.5u l=8u m=1 b=0
XRB13 lad12 lad13 VSS rppd w=0.5u l=8u m=1 b=0
XRB14 lad13 lad14 VSS rppd w=0.5u l=8u m=1 b=0
XRB15 lad14 lad15 VSS rppd w=0.5u l=8u m=1 b=0
XRB16 lad15 lad16 VSS rppd w=0.5u l=8u m=1 b=0
XRB17 lad16 lad17 VSS rppd w=0.5u l=8u m=1 b=0
XRB18 lad17 lad18 VSS rppd w=0.5u l=8u m=1 b=0
XRB19 lad18 lad19 VSS rppd w=0.5u l=8u m=1 b=0
XRB20 lad19 lad20 VSS rppd w=0.5u l=8u m=1 b=0
XRB21 lad20 lad21 VSS rppd w=0.5u l=8u m=1 b=0
XRB22 lad21 refl VSS rppd w=0.5u l=8u m=1 b=0
XRC refl VSS VSS rppd w=0.5u l=8u m=1 b=0
XMFH1 VDD VCTRL vsh VSS sg13_lv_nmos w=2u l=1u ng=1 m=1
XMFH2 VDD refh rsh VSS sg13_lv_nmos w=2u l=1u ng=1 m=1
XMSH1 vsh VDD VSS VSS sg13_lv_nmos w=0.5u l=1u ng=1 m=1
XMSH2 rsh VDD VSS VSS sg13_lv_nmos w=0.5u l=1u ng=1 m=1
XMTH tlh VDD VSS VSS sg13_lv_nmos w=0.5u l=1u ng=1 m=1
XMH1 dh vsh tlh VSS sg13_lv_nmos w=4u l=1u ng=1 m=1
XMH2 oh rsh tlh VSS sg13_lv_nmos w=4u l=1u ng=1 m=1
XMLH1 dh dh VDD VDD sg13_lv_pmos w=2u l=1u ng=1 m=1
XMLH2 oh dh VDD VDD sg13_lv_pmos w=2u l=1u ng=1 m=1
XH1 oh ohb VDD VSS inv_lv
XH2 ohb NHI VDD VSS inv_lv
XMFL1 VSS VCTRL vsl VDD sg13_lv_pmos w=8u l=0.13u ng=1 m=1
XMFL2 VSS refl rsl VDD sg13_lv_pmos w=8u l=0.13u ng=1 m=1
XMSL1 vsl VSS VDD VDD sg13_lv_pmos w=1.5u l=1u ng=1 m=1
XMSL2 rsl VSS VDD VDD sg13_lv_pmos w=1.5u l=1u ng=1 m=1
XMTL tll VSS VDD VDD sg13_lv_pmos w=1.5u l=1u ng=1 m=1
XMPL1 dl rsl tll VDD sg13_lv_pmos w=4u l=0.5u ng=1 m=1
XMPL2 ol vsl tll VDD sg13_lv_pmos w=4u l=0.5u ng=1 m=1
XMLL1 dl dl VSS VSS sg13_lv_nmos w=1u l=0.5u ng=1 m=1
XMLL2 ol dl VSS VSS sg13_lv_nmos w=1u l=0.5u ng=1 m=1
XL1 ol olb VDD VSS inv_lv
XL2 olb NLO VDD VSS inv_lv
XNH NHI nhi_n VDD VSS inv_lv
XNL NLO nlo_n VDD VSS inv_lv
XNE nhi_n nlo_n NEAR VDD VSS nand2_lv
.ends

* expanding   symbol:  nand2_lv.sym # of pins=5
** sym_path: design/nand2_lv.sym
** sch_path: design/nand2_lv.sch
.subckt nand2_lv A1 A2 Y VDD VSS
*.ipin A1
*.ipin A2
*.opin Y
*.iopin VDD
*.iopin VSS
XMP1 Y A1 VDD VDD sg13_lv_pmos w=1u l=0.13u ng=1 m=1
XMP2 Y A2 VDD VDD sg13_lv_pmos w=1u l=0.13u ng=1 m=1
XMN1 Y A1 mid VSS sg13_lv_nmos w=1u l=0.13u ng=1 m=1
XMN2 mid A2 VSS VSS sg13_lv_nmos w=1u l=0.13u ng=1 m=1
.ends

* expanding   symbol:  inv_lv.sym # of pins=4
** sym_path: design/inv_lv.sym
** sch_path: design/inv_lv.sch
.subckt inv_lv A Y VDD VSS
*.ipin A
*.opin Y
*.iopin VDD
*.iopin VSS
XMP Y A VDD VDD sg13_lv_pmos w=1u l=0.13u ng=1 m=1
XMN Y A VSS VSS sg13_lv_nmos w=0.5u l=0.13u ng=1 m=1
.ends

* expanding   symbol:  timeout_cnt.sym # of pins=5
** sym_path: design/timeout_cnt.sym
** sch_path: design/timeout_cnt.sch
.subckt timeout_cnt REF NEAR TO VDD VSS
*.ipin REF
*.ipin NEAR
*.opin TO
*.iopin VDD
*.iopin VSS
XC1 qb1 REF NEAR q1 qb1 VDD VSS dffr_lv
XC2 qb2 qb1 NEAR q2 qb2 VDD VSS dffr_lv
XC3 qb3 qb2 NEAR q3 qb3 VDD VSS dffr_lv
XC4 qb4 qb3 NEAR q4 qb4 VDD VSS dffr_lv
XC5 qb5 qb4 NEAR TO qb5 VDD VSS dffr_lv
.ends

* expanding   symbol:  edgedet.sym # of pins=4
** sym_path: design/edgedet.sym
** sch_path: design/edgedet.sch
.subckt edgedet X OUT VDD VSS
*.ipin X
*.opin OUT
*.iopin VDD
*.iopin VSS
XMPD1 d1 X VDD VDD sg13_lv_pmos w=1u l=0.16u ng=1 m=1
XMND1 d1 X VSS VSS sg13_lv_nmos w=0.5u l=0.16u ng=1 m=1
XMPD2 d2 d1 VDD VDD sg13_lv_pmos w=1u l=0.16u ng=1 m=1
XMND2 d2 d1 VSS VSS sg13_lv_nmos w=0.5u l=0.16u ng=1 m=1
XMPD3 d3 d2 VDD VDD sg13_lv_pmos w=1u l=0.16u ng=1 m=1
XMND3 d3 d2 VSS VSS sg13_lv_nmos w=0.5u l=0.16u ng=1 m=1
XN1 X d3 ntmp VDD VSS nand2_lv
XOUT ntmp OUT VDD VSS inv_lv
.ends

* expanding   symbol:  nand3_lv.sym # of pins=6
** sym_path: design/nand3_lv.sym
** sch_path: design/nand3_lv.sch
.subckt nand3_lv A1 A2 A3 Y VDD VSS
*.ipin A1
*.ipin A2
*.ipin A3
*.opin Y
*.iopin VDD
*.iopin VSS
XMP1 Y A1 VDD VDD sg13_lv_pmos w=1u l=0.13u ng=1 m=1
XMP2 Y A2 VDD VDD sg13_lv_pmos w=1u l=0.13u ng=1 m=1
XMP3 Y A3 VDD VDD sg13_lv_pmos w=1u l=0.13u ng=1 m=1
XMN1 Y A1 m1 VSS sg13_lv_nmos w=1.5u l=0.13u ng=1 m=1
XMN2 m1 A2 m2 VSS sg13_lv_nmos w=1.5u l=0.13u ng=1 m=1
XMN3 m2 A3 VSS VSS sg13_lv_nmos w=1.5u l=0.13u ng=1 m=1
.ends

* expanding   symbol:  srlatch.sym # of pins=6
** sym_path: design/srlatch.sym
** sch_path: design/srlatch.sch
.subckt srlatch S R Q QB VDD VSS
*.ipin S
*.ipin R
*.opin Q
*.opin QB
*.iopin VDD
*.iopin VSS
XIS S SB VDD VSS inv_lv
XIR R RB VDD VSS inv_lv
XNQ SB QB Q VDD VSS nand2_lv
XNQB RB Q QB VDD VSS nand2_lv
.ends

* expanding   symbol:  refmask.sym # of pins=5
** sym_path: design/refmask.sym
** sch_path: design/refmask.sch
.subckt refmask REF RSTB REFM VDD VSS
*.ipin REF
*.ipin RSTB
*.opin REFM
*.iopin VDD
*.iopin VSS
XIR REF refb VDD VSS inv_lv
XEN VDD refb RSTB en en_n VDD VSS dffr_lv
XAN REF en refm_n VDD VSS nand2_lv
XAI refm_n REFM VDD VSS inv_lv
.ends

* expanding   symbol:  dffr_lv.sym # of pins=7
** sym_path: design/dffr_lv.sym
** sch_path: design/dffr_lv.sch
.subckt dffr_lv D CK CLRB Q QB VDD VSS
*.ipin D
*.ipin CK
*.ipin CLRB
*.opin Q
*.opin QB
*.iopin VDD
*.iopin VSS
XIC CK ckb VDD VSS inv_lv
XID D dn VDD VSS inv_lv
XSM D ckb CLRB sm VDD VSS nand3_lv
XRM dn ckb rm VDD VSS nand2_lv
XQM sm qmb qm VDD VSS nand2_lv
XQMB rm qm CLRB qmb VDD VSS nand3_lv
XSS qm CK CLRB ss VDD VSS nand3_lv
XRS qmb CK rs VDD VSS nand2_lv
XQ ss QB Q VDD VSS nand2_lv
XQB rs Q CLRB QB VDD VSS nand3_lv
.ends

* expanding   symbol:  dffr_fast.sym # of pins=7
** sym_path: design/dffr_fast.sym
** sch_path: design/dffr_fast.sch
.subckt dffr_fast D CK CLRB Q QB VDD VSS
*.ipin D
*.ipin CK
*.ipin CLRB
*.opin Q
*.opin QB
*.iopin VDD
*.iopin VSS
XIC CK ckb VDD VSS inv_lv
XID D dn VDD VSS inv2x_lv
XSM D ckb CLRB sm VDD VSS nand3_lv
XRM dn ckb rm VDD VSS nand2x_lv
XQM sm qmb qm VDD VSS nand2x_lv
XQMB rm qm CLRB qmb VDD VSS nand3x_lv
XD1 CK ckd1 VDD VSS inv_lv
XD2 ckd1 ckd VDD VSS inv_lv
XSS qm ckd CLRB ss VDD VSS nand3_lv
XRS qmb ckd rs VDD VSS nand2_lv
XQ ss QB Q VDD VSS nand2_lv
XQB rs Q CLRB QB VDD VSS nand3_lv
.ends

* expanding   symbol:  inv2x_lv.sym # of pins=4
** sym_path: design/inv2x_lv.sym
** sch_path: design/inv2x_lv.sch
.subckt inv2x_lv A Y VDD VSS
*.ipin A
*.opin Y
*.iopin VDD
*.iopin VSS
XMP Y A VDD VDD sg13_lv_pmos w=2u l=0.13u ng=1 m=1
XMN Y A VSS VSS sg13_lv_nmos w=1u l=0.13u ng=1 m=1
.ends

* expanding   symbol:  nand2x_lv.sym # of pins=5
** sym_path: design/nand2x_lv.sym
** sch_path: design/nand2x_lv.sch
.subckt nand2x_lv A1 A2 Y VDD VSS
*.ipin A1
*.ipin A2
*.opin Y
*.iopin VDD
*.iopin VSS
XMP1 Y A1 VDD VDD sg13_lv_pmos w=2u l=0.13u ng=1 m=1
XMP2 Y A2 VDD VDD sg13_lv_pmos w=2u l=0.13u ng=1 m=1
XMN1 Y A1 mid VSS sg13_lv_nmos w=2u l=0.13u ng=1 m=1
XMN2 mid A2 VSS VSS sg13_lv_nmos w=2u l=0.13u ng=1 m=1
.ends

* expanding   symbol:  nand3x_lv.sym # of pins=6
** sym_path: design/nand3x_lv.sym
** sch_path: design/nand3x_lv.sch
.subckt nand3x_lv A1 A2 A3 Y VDD VSS
*.ipin A1
*.ipin A2
*.ipin A3
*.opin Y
*.iopin VDD
*.iopin VSS
XMP1 Y A1 VDD VDD sg13_lv_pmos w=2u l=0.13u ng=1 m=1
XMP2 Y A2 VDD VDD sg13_lv_pmos w=2u l=0.13u ng=1 m=1
XMP3 Y A3 VDD VDD sg13_lv_pmos w=2u l=0.13u ng=1 m=1
XMN1 Y A1 m1 VSS sg13_lv_nmos w=3u l=0.13u ng=1 m=1
XMN2 m1 A2 m2 VSS sg13_lv_nmos w=3u l=0.13u ng=1 m=1
XMN3 m2 A3 VSS VSS sg13_lv_nmos w=3u l=0.13u ng=1 m=1
.ends

* win_det / dffr_lv setup-margin probe body (issue #189, the supervisor half
* of the #145/#148 ss diagnosis). Deck = design/netlist/supervisor.spice (the
* committed export; win_det and its siblings used verbatim) + this body.
* Not a design.
* The no-fault phase of the committed smoke stimulus (decks/sup_body.spice,
* d = 0.8 T) puts the TAPH falling edge 100 ps (50 % crossings of VDD) before
* the SECOND REF rising edge; the tt record captures low there and the ss probe
* (results/20261115T185844Z-probe/) mis-latches high. This probe sweeps that
* lead: REF is the smoke bench's own clock (Vck: 0.5 ns base delay, 30 ps
* edges, 1 ns period, vdd-scaled); TAPN is the unchanged 0.8 T copy; TAPH is
* ONE pulse whose fall 50 % point sits `lead` ps before the second REF rise,
* shaped (30 ps linear edges, the smoke slew) from the Vlead DC source
* (V = lead in ns: 0.100 V = 100 ps, the no-fault lead; lead < 0 means TAPH
* falls after the sampling edge, which must capture high at any corner).
* `lead` is swept across units through corners.supply_v (an alter of the Vlead
* source; the harness ic axis), NOT corners.params (the fleet runner image can
* lag the client -- sim/harness/gridspec.py).
* The sampler is the committed win_det itself with its supervisor-internal
* loads (REF drives XIREF + three dffr_lv CK inputs; TAPH drives XBUP.D), and
* `over` carries the XIPO inv_lv load it sees inside supervisor, so the load
* is the smoke bench's own. b_up is scored settled (at 2.4 ns, after the same
* clock edge, before the next) against 50 % of the corner's own rail (v(half)),
* so the same request grades every corner. The crossing times of the actual
* pins (t_ref_r2, t_taph_f) are recorded too, so every unit's true lead is
* read from the run, never assumed from the source parameter. Results are
* simulated, never measured.
Vdd vdd 0 1.2
Vck ck 0 PULSE(0 1 0.5n 30p 30p 0.47n 1n)
Vtn tn 0 PULSE(0 1 1.3n 30p 30p 0.47n 1n)
Vlead lead 0 DC 0.100
Bref ref 0 V = v(vdd)*v(ck)
Btapn tapn 0 V = v(vdd)*v(tn)
Btaph taph 0 V = v(vdd)*(((uramp(time-0.885e-9)/30e-12)-(uramp(uramp(time-0.885e-9)/30e-12-1)))-((uramp(time-1.500e-9+v(lead)*1e-9)/30e-12)-(uramp(uramp(time-1.500e-9+v(lead)*1e-9)/30e-12-1))))
Bhalf half 0 V = 0.5*v(vdd)
XWIN ref tapn taph over vdd 0 win_det
XLO over over_ld vdd 0 inv_lv
