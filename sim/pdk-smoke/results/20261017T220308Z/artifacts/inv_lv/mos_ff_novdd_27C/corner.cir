* klt sim -- generated corner deck, do not edit
.lib /var/tmp/eda-job-klt-sim-0d1720ca1e9f/inputs/cornerMOSlv.lib mos_ff
.include /var/tmp/eda-job-klt-sim-0d1720ca1e9f/inputs/netlist.cir
.temp 27
.meas tran voh find v(out) at=0.9n
.meas tran vol find v(out) at=2.0n
.meas tran tphl trig v(in) val=0.6 rise=1 targ v(out) val=0.6 fall=1
.meas tran tplh trig v(in) val=0.6 fall=1 targ v(out) val=0.6 rise=1
.control
pre_osdi /var/tmp/eda-job-klt-sim-0d1720ca1e9f/inputs/psp103.osdi
pre_osdi /var/tmp/eda-job-klt-sim-0d1720ca1e9f/inputs/psp103_nqs.osdi
pre_osdi /var/tmp/eda-job-klt-sim-0d1720ca1e9f/inputs/r3_cmc.osdi
pre_osdi /var/tmp/eda-job-klt-sim-0d1720ca1e9f/inputs/mosvar.osdi
save all
tran 5p 6n
quit
.endc
.end
