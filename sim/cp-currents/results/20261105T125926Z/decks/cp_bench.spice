* sg13g2-dll :: cp_bias -- generated by design/netlist.sh from design/cp_bias.sch
* do not edit by hand; regenerate with design/netlist.sh
** sch_path: design/cp_bias.sch
.subckt cp_bias IBP ICP IBN ICN VDD VSS
*.opin IBP
*.opin ICP
*.opin IBN
*.opin ICN
*.iopin VDD
*.iopin VSS
XMR ICN VSS VDD VDD sg13_lv_pmos w=0.5u l=4u ng=1 m=1
XMN3 ICN ICN IBN VSS sg13_lv_nmos w=2u l=0.5u ng=1 m=1
XMN0 IBN IBN VSS VSS sg13_lv_nmos w=2u l=0.5u ng=1 m=1
XMP0 IBP IBP VDD VDD sg13_lv_pmos w=6u l=0.5u ng=1 m=1
XMP3 ICP ICP IBP VDD sg13_lv_pmos w=6u l=0.5u ng=1 m=1
XMN4 ICP IBN VSS VSS sg13_lv_nmos w=2u l=0.5u ng=1 m=1
.ends
* sg13g2-dll :: cp -- generated by design/netlist.sh from design/cp.sch
* do not edit by hand; regenerate with design/netlist.sh
** sch_path: design/cp.sch
.subckt cp UP DN IBP ICP IBN ICN VOUT VDD VSS
*.ipin UP
*.ipin DN
*.ipin IBP
*.ipin ICP
*.ipin IBN
*.ipin ICN
*.opin VOUT
*.iopin VDD
*.iopin VSS
XIUP UP UPB VDD VSS inv_lv
XIDN DN DNB VDD VSS inv_lv
XLEGP IBP ICP UP UPB VOUT VDUMP VDD cp_leg_p
XLEGN IBN ICN DN DNB VOUT VDUMP VSS cp_leg_n
XBUF VOUT IBN VDUMP VDD VSS cp_dumpbuf
.ends

* expanding   symbol:  inv_lv.sym # of pins=4
** sym_path: design/inv_lv.sym
** sch_path: design/inv_lv.sch
.subckt inv_lv A Y VDD VSS
*.ipin A
*.opin Y
*.iopin VDD
*.iopin VSS
XMP Y A VDD VDD sg13_lv_pmos w=1u l=0.13u ng=1 m=1
XMN Y A VSS VSS sg13_lv_nmos w=0.5u l=0.13u ng=1 m=1
.ends

* expanding   symbol:  cp_leg_p.sym # of pins=7
** sym_path: design/cp_leg_p.sym
** sch_path: design/cp_leg_p.sch
.subckt cp_leg_p IBP ICP UP UPB VOUT VDUMP VDD
*.ipin IBP
*.ipin ICP
*.ipin UP
*.ipin UPB
*.opin VOUT
*.opin VDUMP
*.iopin VDD
XM1 tail IBP VDD VDD sg13_lv_pmos w=6u l=0.5u ng=1 m=1
XM2 sw ICP tail VDD sg13_lv_pmos w=6u l=0.5u ng=1 m=1
XXSWO VOUT UPB sw VDD sg13_lv_pmos w=3u l=0.13u ng=1 m=1
XXSWD VDUMP UP sw VDD sg13_lv_pmos w=3u l=0.13u ng=1 m=1
.ends

* expanding   symbol:  cp_leg_n.sym # of pins=7
** sym_path: design/cp_leg_n.sym
** sch_path: design/cp_leg_n.sch
.subckt cp_leg_n IBN ICN DN DNB VOUT VDUMP VSS
*.ipin IBN
*.ipin ICN
*.ipin DN
*.ipin DNB
*.opin VOUT
*.opin VDUMP
*.iopin VSS
XM1 tail IBN VSS VSS sg13_lv_nmos w=2u l=0.5u ng=1 m=1
XM2 sw ICN tail VSS sg13_lv_nmos w=2u l=0.5u ng=1 m=1
XXSWO VOUT DN sw VSS sg13_lv_nmos w=1u l=0.13u ng=1 m=1
XXSWD VDUMP DNB sw VSS sg13_lv_nmos w=1u l=0.13u ng=1 m=1
.ends

* expanding   symbol:  cp_dumpbuf.sym # of pins=5
** sym_path: design/cp_dumpbuf.sym
** sch_path: design/cp_dumpbuf.sch
.subckt cp_dumpbuf VOUT IBIAS VDUMP VDD VSS
*.ipin VOUT
*.ipin IBIAS
*.opin VDUMP
*.iopin VDD
*.iopin VSS
XM1 VDD VOUT VDUMP VSS sg13_lv_nmos w=2u l=0.25u ng=1 m=1
XM2 VDUMP IBIAS VSS VSS sg13_lv_nmos w=1u l=0.5u ng=1 m=1
.ends

* charge-pump bench body (issue #30). run.sh prepends design/netlist/cp_bias.spice and
* design/netlist/cp.spice (the committed exports). Not a design.
* VOUT is held by an ideal source, so i(Vo) is the pump's output current (positive = sourced
* into VOUT). UP/DN are ideal logic with 100 ps edges, amplitude = the corner's own Vdd.
*   40-60 ns   UP only            -> I_up   (avg 50-60 ns)
*   80-100 ns  DN only            -> I_dn   (avg 90-100 ns, negative)
*   105-115 ns idle               -> leakage, and I(Vdd) = bias + idle current
*   120-140 ns UP and DN together -> net current (mismatch)
*   160 ns     one 200 ps UP pulse -> charge per pulse (integral 159-175 ns)
*   180 ns     one 200 ps DN pulse -> charge per pulse (integral 179-195 ns)
*   VOUT 0.6 V until 200 ns, 0.3 V 202-240 ns, 0.9 V 242-280 ns; idle -> dump-buffer VDUMP tracking
Vdd vdd 0 1.2
Vo vout 0 PWL(0 0.6 200n 0.6 202n 0.3 240n 0.3 242n 0.9 300n 0.9)
Bup up 0 V = v(vdd)*pwl(time, 0,0, 40n,0, 40.1n,1, 60n,1, 60.1n,0, 120n,0, 120.1n,1, 140n,1, 140.1n,0, 160n,0, 160.1n,1, 160.3n,1, 160.4n,0)
Bdn dn 0 V = v(vdd)*pwl(time, 0,0, 80n,0, 80.1n,1, 100n,1, 100.1n,0, 120n,0, 120.1n,1, 140n,1, 140.1n,0, 180n,0, 180.1n,1, 180.3n,1, 180.4n,0)
XB ibp icp ibn icn vdd 0 cp_bias
XDUT up dn ibp icp ibn icn vout vdd 0 cp
