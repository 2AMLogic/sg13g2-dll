* klt sim -- generated corner deck, do not edit
.lib /var/tmp/eda-job-klt-sim-f84a6010930b/inputs/cornerMOSlv.lib mos_ff
.include /var/tmp/eda-job-klt-sim-f84a6010930b/inputs/netlist.cir
.temp -40
.meas tran d1 trig v(t0) val=0.66 rise=1 targ v(t1) val=0.66 rise=1
.meas tran d2 trig v(t0) val=0.66 rise=1 targ v(t2) val=0.66 rise=1
.meas tran d3 trig v(t0) val=0.66 rise=1 targ v(t3) val=0.66 rise=1
.meas tran d4 trig v(t0) val=0.66 rise=1 targ v(t4) val=0.66 rise=1
.meas tran d5 trig v(t0) val=0.66 rise=1 targ v(t5) val=0.66 rise=1
.meas tran d6 trig v(t0) val=0.66 rise=1 targ v(t6) val=0.66 rise=1
.meas tran d7 trig v(t0) val=0.66 rise=1 targ v(t7) val=0.66 rise=1
.meas tran d8 trig v(t0) val=0.66 rise=1 targ v(t8) val=0.66 rise=1
.control
pre_osdi /var/tmp/eda-job-klt-sim-f84a6010930b/inputs/psp103.osdi
pre_osdi /var/tmp/eda-job-klt-sim-f84a6010930b/inputs/psp103_nqs.osdi
pre_osdi /var/tmp/eda-job-klt-sim-f84a6010930b/inputs/r3_cmc.osdi
pre_osdi /var/tmp/eda-job-klt-sim-f84a6010930b/inputs/mosvar.osdi
save all
alter VC=0.9
alter Vdd=1.32
tran 5p 8n
quit
.endc
.end
